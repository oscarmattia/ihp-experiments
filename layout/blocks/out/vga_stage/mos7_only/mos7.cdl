* vga_dut — generated from DeviceSpecs; do not edit by hand
.SUBCKT vga_dut mgate vss tx1 tx2 em steerp steern ed1 ed2
M1 mgate mgate vss vss sg13_lv_nmos w=246.875u l=1u ng=1 m=1
M2 tx1 mgate vss vss sg13_lv_nmos w=246.875u l=1u ng=1 m=1
M3 tx2 mgate vss vss sg13_lv_nmos w=246.875u l=1u ng=1 m=1
M4 tx1 steerp em vss sg13_lv_nmos w=200u l=0.5u ng=1 m=1
M5 tx2 steerp em vss sg13_lv_nmos w=200u l=0.5u ng=1 m=1
M6 tx1 steern ed1 vss sg13_lv_nmos w=200u l=0.5u ng=1 m=1
M7 tx2 steern ed2 vss sg13_lv_nmos w=200u l=0.5u ng=1 m=1
.ENDS vga_dut
