* Extracted by KLayout with SG13G2 LVS runset on : 20/08/2026 08:47

.SUBCKT vga_dut
M$1 \$2 \$2 \$2 \$1 sg13_lv_nmos L=0.96u W=50u AS=17p AD=17p PS=103.4u
+ PD=103.4u rfmode=0
M$6 \$2 \$2 \$2 \$1 sg13_lv_nmos L=0.5u W=300u AS=102p AD=102p PS=620.4u
+ PD=620.4u rfmode=0
M$36 \$2 \$I21 \$I20 \$1 sg13_lv_nmos L=0.5u W=200u AS=68p AD=68p PS=413.6u
+ PD=413.6u rfmode=0
M$56 \$2 \$I23 \$I22 \$1 sg13_lv_nmos L=0.5u W=200u AS=68p AD=68p PS=413.6u
+ PD=413.6u rfmode=0
M$76 \$2 \$I24 \$4 \$1 sg13_lv_nmos L=1u W=246.75u AS=83.895p AD=83.895p
+ PS=510.5u PD=510.5u rfmode=0
M$101 \$2 \$I25 \$4 \$1 sg13_lv_nmos L=1u W=246.75u AS=83.895p AD=83.895p
+ PS=510.5u PD=510.5u rfmode=0
M$126 \$I26 \$I27 \$4 \$1 sg13_lv_nmos L=1u W=246.75u AS=83.895p AD=83.895p
+ PS=510.5u PD=510.5u rfmode=0
.ENDS vga_dut
