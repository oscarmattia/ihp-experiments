* vga_dut — generated from DeviceSpecs; do not edit by hand
.SUBCKT vga_dut mgate vss
M1 mgate mgate vss vss sg13_lv_nmos w=246.875u l=1u ng=1 m=1
M2 tx1 mgate vss vss sg13_lv_nmos w=246.875u l=1u ng=1 m=1
M3 tx2 mgate vss vss sg13_lv_nmos w=246.875u l=1u ng=1 m=1
.ENDS vga_dut
