* Extracted by KLayout with SG13G2 LVS runset on : 20/08/2026 08:47

.SUBCKT vga_dut
R$1 \$I361 \$1 ptap1 A=0.6084p P=3.12u
R$2 \$I362 \$1 ptap1 A=0.6084p P=3.12u
R$3 \$I363 \$1 ptap1 A=0.6084p P=3.12u
R$4 \$I364 \$1 ptap1 A=0.6084p P=3.12u
R$5 \$I365 \$1 ptap1 A=0.6084p P=3.12u
R$6 \$I366 \$1 ptap1 A=0.6084p P=3.12u
R$7 \$I367 \$1 ptap1 A=0.6084p P=3.12u
R$8 \$I368 \$1 ptap1 A=0.6084p P=3.12u
R$9 \$I369 \$1 ptap1 A=0.6084p P=3.12u
R$10 \$I370 \$1 ptap1 A=0.6084p P=3.12u
R$11 \$I371 \$1 ptap1 A=0.6084p P=3.12u
R$12 \$I372 \$1 ptap1 A=0.6084p P=3.12u
R$13 \$I373 \$1 ptap1 A=0.6084p P=3.12u
R$14 \$I374 \$1 ptap1 A=0.6084p P=3.12u
R$15 \$I375 \$1 ptap1 A=0.6084p P=3.12u
R$16 \$I376 \$1 ptap1 A=0.6084p P=3.12u
R$17 \$I377 \$1 ptap1 A=0.6084p P=3.12u
R$18 \$I378 \$1 ptap1 A=0.6084p P=3.12u
R$19 \$I379 \$1 ptap1 A=0.6084p P=3.12u
R$20 \$I380 \$1 ptap1 A=0.6084p P=3.12u
R$21 \$I381 \$1 ptap1 A=0.6084p P=3.12u
R$22 \$I382 \$1 ptap1 A=0.6084p P=3.12u
R$23 \$I383 \$1 ptap1 A=0.6084p P=3.12u
R$24 \$I384 \$1 ptap1 A=0.6084p P=3.12u
R$25 \$I385 \$1 ptap1 A=0.6084p P=3.12u
R$26 \$I386 \$1 ptap1 A=0.6084p P=3.12u
R$27 \$I387 \$1 ptap1 A=0.6084p P=3.12u
R$28 \$I388 \$1 ptap1 A=0.6084p P=3.12u
R$29 \$I389 \$1 ptap1 A=0.6084p P=3.12u
R$30 \$I390 \$1 ptap1 A=0.6084p P=3.12u
R$31 \$I391 \$1 ptap1 A=0.6084p P=3.12u
R$32 \$I392 \$1 ptap1 A=0.6084p P=3.12u
R$33 \$I393 \$1 ptap1 A=0.6084p P=3.12u
R$34 \$I394 \$1 ptap1 A=0.6084p P=3.12u
R$35 \$I395 \$1 ptap1 A=0.6084p P=3.12u
R$36 \$I396 \$1 ptap1 A=0.6084p P=3.12u
R$37 \$I397 \$1 ptap1 A=0.6084p P=3.12u
R$38 \$I398 \$1 ptap1 A=0.6084p P=3.12u
R$39 \$I399 \$1 ptap1 A=0.6084p P=3.12u
R$40 \$I400 \$1 ptap1 A=0.6084p P=3.12u
R$41 \$I401 \$1 ptap1 A=0.6084p P=3.12u
R$42 \$I402 \$1 ptap1 A=0.6084p P=3.12u
R$43 \$I403 \$1 ptap1 A=0.6084p P=3.12u
R$44 \$I404 \$1 ptap1 A=0.6084p P=3.12u
R$45 \$I405 \$1 ptap1 A=0.6084p P=3.12u
R$46 \$I406 \$1 ptap1 A=0.6084p P=3.12u
R$47 \$I407 \$1 ptap1 A=0.6084p P=3.12u
R$48 \$I408 \$1 ptap1 A=0.6084p P=3.12u
R$49 \$I409 \$1 ptap1 A=0.6084p P=3.12u
R$50 \$I410 \$1 ptap1 A=0.6084p P=3.12u
R$51 \$I411 \$1 ptap1 A=0.6084p P=3.12u
R$52 \$I412 \$1 ptap1 A=0.6084p P=3.12u
R$53 \$I413 \$1 ptap1 A=0.6084p P=3.12u
R$54 \$I414 \$1 ptap1 A=0.6084p P=3.12u
R$55 \$I415 \$1 ptap1 A=0.6084p P=3.12u
R$56 \$I416 \$1 ptap1 A=0.6084p P=3.12u
R$57 \$I417 \$1 ptap1 A=0.6084p P=3.12u
R$58 \$I418 \$1 ptap1 A=0.6084p P=3.12u
R$59 \$I419 \$1 ptap1 A=0.6084p P=3.12u
R$60 \$I420 \$1 ptap1 A=0.6084p P=3.12u
R$61 \$I421 \$1 ptap1 A=0.6084p P=3.12u
R$62 \$I422 \$1 ptap1 A=0.6084p P=3.12u
R$63 \$I423 \$1 ptap1 A=0.6084p P=3.12u
R$64 \$I424 \$1 ptap1 A=0.6084p P=3.12u
R$65 \$I425 \$1 ptap1 A=0.6084p P=3.12u
R$66 \$I426 \$1 ptap1 A=0.6084p P=3.12u
R$67 \$I427 \$1 ptap1 A=0.6084p P=3.12u
R$68 \$I428 \$1 ptap1 A=0.6084p P=3.12u
R$69 \$I429 \$1 ptap1 A=0.6084p P=3.12u
R$70 \$I430 \$1 ptap1 A=0.6084p P=3.12u
R$71 \$I431 \$1 ptap1 A=0.6084p P=3.12u
R$72 \$I432 \$1 ptap1 A=0.6084p P=3.12u
R$73 \$I433 \$1 ptap1 A=0.6084p P=3.12u
R$74 \$I434 \$1 ptap1 A=0.6084p P=3.12u
R$75 \$I435 \$1 ptap1 A=0.6084p P=3.12u
R$76 \$I436 \$1 ptap1 A=0.6084p P=3.12u
R$77 \$I437 \$1 ptap1 A=0.6084p P=3.12u
R$78 \$I438 \$1 ptap1 A=0.6084p P=3.12u
R$79 \$I439 \$1 ptap1 A=0.6084p P=3.12u
R$80 \$I440 \$1 ptap1 A=0.6084p P=3.12u
R$81 \$I441 \$1 ptap1 A=0.6084p P=3.12u
R$82 \$I442 \$1 ptap1 A=0.6084p P=3.12u
R$83 \$I443 \$1 ptap1 A=0.6084p P=3.12u
R$84 \$I444 \$1 ptap1 A=0.6084p P=3.12u
R$85 \$I445 \$1 ptap1 A=0.6084p P=3.12u
R$86 \$I446 \$1 ptap1 A=0.6084p P=3.12u
R$87 \$I447 \$1 ptap1 A=0.6084p P=3.12u
R$88 \$I448 \$1 ptap1 A=0.6084p P=3.12u
R$89 \$I449 \$1 ptap1 A=0.6084p P=3.12u
R$90 \$I450 \$1 ptap1 A=0.6084p P=3.12u
R$91 \$I451 \$1 ptap1 A=0.6084p P=3.12u
R$92 \$I452 \$1 ptap1 A=0.6084p P=3.12u
R$93 \$I453 \$1 ptap1 A=0.6084p P=3.12u
R$94 \$I454 \$1 ptap1 A=0.6084p P=3.12u
R$95 \$I455 \$1 ptap1 A=0.6084p P=3.12u
R$96 \$I456 \$1 ptap1 A=0.6084p P=3.12u
R$97 \$I457 \$1 ptap1 A=0.6084p P=3.12u
R$98 \$I458 \$1 ptap1 A=0.6084p P=3.12u
R$99 \$I459 \$1 ptap1 A=0.6084p P=3.12u
R$100 \$I460 \$1 ptap1 A=0.6084p P=3.12u
R$101 \$I461 \$1 ptap1 A=0.6084p P=3.12u
R$102 \$I462 \$1 ptap1 A=0.6084p P=3.12u
R$103 \$I463 \$1 ptap1 A=0.6084p P=3.12u
R$104 \$I464 \$1 ptap1 A=0.6084p P=3.12u
R$105 \$I465 \$1 ptap1 A=0.6084p P=3.12u
R$106 \$I466 \$1 ptap1 A=0.6084p P=3.12u
R$107 \$I467 \$1 ptap1 A=0.6084p P=3.12u
R$108 \$I468 \$1 ptap1 A=0.6084p P=3.12u
R$109 \$I469 \$1 ptap1 A=0.6084p P=3.12u
R$110 \$I470 \$1 ptap1 A=0.6084p P=3.12u
R$111 \$I471 \$1 ptap1 A=0.6084p P=3.12u
R$112 \$I472 \$1 ptap1 A=0.6084p P=3.12u
R$113 \$I473 \$1 ptap1 A=0.6084p P=3.12u
R$114 \$I474 \$1 ptap1 A=0.6084p P=3.12u
R$115 \$I475 \$1 ptap1 A=0.6084p P=3.12u
R$116 \$I476 \$1 ptap1 A=0.6084p P=3.12u
R$117 \$I477 \$1 ptap1 A=0.6084p P=3.12u
R$118 \$I478 \$1 ptap1 A=0.6084p P=3.12u
R$119 \$I479 \$1 ptap1 A=0.6084p P=3.12u
R$120 \$I480 \$1 ptap1 A=0.6084p P=3.12u
R$121 \$I481 \$1 ptap1 A=0.6084p P=3.12u
R$122 \$I482 \$1 ptap1 A=0.6084p P=3.12u
R$123 \$I483 \$1 ptap1 A=0.6084p P=3.12u
R$124 \$I484 \$1 ptap1 A=0.6084p P=3.12u
R$125 \$I485 \$1 ptap1 A=0.6084p P=3.12u
R$126 \$I486 \$1 ptap1 A=0.6084p P=3.12u
R$127 \$I487 \$1 ptap1 A=0.6084p P=3.12u
R$128 \$I488 \$1 ptap1 A=0.6084p P=3.12u
R$129 \$I489 \$1 ptap1 A=0.6084p P=3.12u
R$130 \$I490 \$1 ptap1 A=0.6084p P=3.12u
R$131 \$I491 \$1 ptap1 A=0.6084p P=3.12u
R$132 \$I492 \$1 ptap1 A=0.6084p P=3.12u
R$133 \$I493 \$1 ptap1 A=0.6084p P=3.12u
R$134 \$I494 \$1 ptap1 A=0.6084p P=3.12u
R$135 \$I495 \$1 ptap1 A=0.6084p P=3.12u
R$136 \$I496 \$1 ptap1 A=0.6084p P=3.12u
R$137 \$I497 \$1 ptap1 A=0.6084p P=3.12u
R$138 \$I498 \$1 ptap1 A=0.6084p P=3.12u
R$139 \$I499 \$1 ptap1 A=0.6084p P=3.12u
R$140 \$I500 \$1 ptap1 A=0.6084p P=3.12u
R$141 \$I501 \$1 ptap1 A=0.6084p P=3.12u
R$142 \$I502 \$1 ptap1 A=0.6084p P=3.12u
R$143 \$I503 \$1 ptap1 A=0.6084p P=3.12u
R$144 \$I504 \$1 ptap1 A=0.6084p P=3.12u
R$145 \$I505 \$1 ptap1 A=0.6084p P=3.12u
R$146 \$I506 \$1 ptap1 A=0.6084p P=3.12u
R$147 \$I507 \$1 ptap1 A=0.6084p P=3.12u
R$148 \$I508 \$1 ptap1 A=0.6084p P=3.12u
R$149 \$I509 \$1 ptap1 A=0.6084p P=3.12u
R$150 \$I510 \$1 ptap1 A=0.6084p P=3.12u
R$151 \$I511 \$1 ptap1 A=0.6084p P=3.12u
R$152 \$I512 \$1 ptap1 A=0.6084p P=3.12u
R$153 \$I513 \$1 ptap1 A=0.6084p P=3.12u
R$154 \$I514 \$1 ptap1 A=0.6084p P=3.12u
R$155 \$I515 \$1 ptap1 A=0.6084p P=3.12u
R$156 \$I516 \$1 ptap1 A=0.6084p P=3.12u
R$157 \$I517 \$1 ptap1 A=0.6084p P=3.12u
R$158 \$I518 \$1 ptap1 A=0.6084p P=3.12u
R$159 \$I519 \$1 ptap1 A=0.6084p P=3.12u
R$160 \$I520 \$1 ptap1 A=0.6084p P=3.12u
R$161 \$I521 \$1 ptap1 A=0.6084p P=3.12u
R$162 \$I522 \$1 ptap1 A=0.6084p P=3.12u
R$163 \$I523 \$1 ptap1 A=0.6084p P=3.12u
R$164 \$I524 \$1 ptap1 A=0.6084p P=3.12u
R$165 \$I525 \$1 ptap1 A=0.6084p P=3.12u
R$166 \$I526 \$1 ptap1 A=0.6084p P=3.12u
R$167 \$I527 \$1 ptap1 A=0.6084p P=3.12u
R$168 \$I528 \$1 ptap1 A=0.6084p P=3.12u
R$169 \$I529 \$1 ptap1 A=0.6084p P=3.12u
R$170 \$I530 \$1 ptap1 A=0.6084p P=3.12u
R$171 \$I531 \$1 ptap1 A=0.6084p P=3.12u
R$172 \$I532 \$1 ptap1 A=0.6084p P=3.12u
R$173 \$I533 \$1 ptap1 A=0.6084p P=3.12u
R$174 \$I534 \$1 ptap1 A=0.6084p P=3.12u
R$175 \$I535 \$1 ptap1 A=0.6084p P=3.12u
R$176 \$I536 \$1 ptap1 A=0.6084p P=3.12u
R$177 \$I537 \$1 ptap1 A=0.6084p P=3.12u
R$178 \$I538 \$1 ptap1 A=0.6084p P=3.12u
R$179 \$I539 \$1 ptap1 A=0.6084p P=3.12u
R$180 \$I540 \$1 ptap1 A=0.6084p P=3.12u
R$181 \$I541 \$1 ptap1 A=0.6084p P=3.12u
R$182 \$I542 \$1 ptap1 A=0.6084p P=3.12u
R$183 \$I543 \$1 ptap1 A=0.6084p P=3.12u
R$184 \$I544 \$1 ptap1 A=0.6084p P=3.12u
R$185 \$I545 \$1 ptap1 A=0.6084p P=3.12u
R$186 \$I546 \$1 ptap1 A=0.6084p P=3.12u
R$187 \$I547 \$1 ptap1 A=0.6084p P=3.12u
R$188 \$I548 \$1 ptap1 A=0.6084p P=3.12u
R$189 \$I549 \$1 ptap1 A=0.6084p P=3.12u
R$190 \$I550 \$1 ptap1 A=0.6084p P=3.12u
R$191 \$I551 \$1 ptap1 A=0.6084p P=3.12u
R$192 \$I552 \$1 ptap1 A=0.6084p P=3.12u
R$193 \$I553 \$1 ptap1 A=0.6084p P=3.12u
R$194 \$I554 \$1 ptap1 A=0.6084p P=3.12u
R$195 \$I555 \$1 ptap1 A=0.6084p P=3.12u
R$196 \$I556 \$1 ptap1 A=0.6084p P=3.12u
R$197 \$I557 \$1 ptap1 A=0.6084p P=3.12u
R$198 \$I558 \$1 ptap1 A=0.6084p P=3.12u
R$199 \$I559 \$1 ptap1 A=0.6084p P=3.12u
R$200 \$I560 \$1 ptap1 A=0.6084p P=3.12u
R$201 \$I561 \$1 ptap1 A=0.6084p P=3.12u
R$202 \$I562 \$1 ptap1 A=0.6084p P=3.12u
R$203 \$I563 \$1 ptap1 A=0.6084p P=3.12u
R$204 \$I564 \$1 ptap1 A=0.6084p P=3.12u
R$205 \$I565 \$1 ptap1 A=0.6084p P=3.12u
R$206 \$I566 \$1 ptap1 A=0.6084p P=3.12u
R$207 \$I567 \$1 ptap1 A=0.6084p P=3.12u
R$208 \$I568 \$1 ptap1 A=0.6084p P=3.12u
R$209 \$I569 \$1 ptap1 A=0.6084p P=3.12u
R$210 \$I570 \$1 ptap1 A=0.6084p P=3.12u
R$211 \$I571 \$1 ptap1 A=0.6084p P=3.12u
R$212 \$I572 \$1 ptap1 A=0.6084p P=3.12u
R$213 \$I573 \$1 ptap1 A=0.6084p P=3.12u
R$214 \$I574 \$1 ptap1 A=0.6084p P=3.12u
R$215 \$I575 \$1 ptap1 A=0.6084p P=3.12u
R$216 \$I576 \$1 ptap1 A=0.6084p P=3.12u
R$217 \$I577 \$1 ptap1 A=0.6084p P=3.12u
R$218 \$I578 \$1 ptap1 A=0.6084p P=3.12u
R$219 \$I579 \$1 ptap1 A=0.6084p P=3.12u
R$220 \$I580 \$1 ptap1 A=0.6084p P=3.12u
R$221 \$I581 \$1 ptap1 A=0.6084p P=3.12u
R$222 \$I582 \$1 ptap1 A=0.6084p P=3.12u
R$223 \$I583 \$1 ptap1 A=0.6084p P=3.12u
R$224 \$I584 \$1 ptap1 A=0.6084p P=3.12u
R$225 \$I585 \$1 ptap1 A=0.6084p P=3.12u
R$226 \$I586 \$1 ptap1 A=0.6084p P=3.12u
R$227 \$I587 \$1 ptap1 A=0.6084p P=3.12u
R$228 \$I588 \$1 ptap1 A=0.6084p P=3.12u
R$229 \$I589 \$1 ptap1 A=0.6084p P=3.12u
R$230 \$I590 \$1 ptap1 A=0.6084p P=3.12u
R$231 \$I591 \$1 ptap1 A=0.6084p P=3.12u
R$232 \$I592 \$1 ptap1 A=0.6084p P=3.12u
R$233 \$I593 \$1 ptap1 A=0.6084p P=3.12u
R$234 \$I594 \$1 ptap1 A=0.6084p P=3.12u
R$235 \$I595 \$1 ptap1 A=0.6084p P=3.12u
R$236 \$I596 \$1 ptap1 A=0.6084p P=3.12u
R$237 \$I597 \$1 ptap1 A=0.6084p P=3.12u
R$238 \$I598 \$1 ptap1 A=0.6084p P=3.12u
R$239 \$I599 \$1 ptap1 A=0.6084p P=3.12u
R$240 \$I600 \$1 ptap1 A=0.6084p P=3.12u
R$241 \$I601 \$1 ptap1 A=0.6084p P=3.12u
R$242 \$I602 \$1 ptap1 A=0.6084p P=3.12u
R$243 \$I603 \$1 ptap1 A=0.6084p P=3.12u
R$244 \$I604 \$1 ptap1 A=0.6084p P=3.12u
R$245 \$I605 \$1 ptap1 A=0.6084p P=3.12u
R$246 \$I606 \$1 ptap1 A=0.6084p P=3.12u
R$247 \$I607 \$1 ptap1 A=0.6084p P=3.12u
R$248 \$I608 \$1 ptap1 A=0.6084p P=3.12u
R$249 \$I609 \$1 ptap1 A=0.6084p P=3.12u
R$250 \$I610 \$1 ptap1 A=0.6084p P=3.12u
R$251 \$I611 \$1 ptap1 A=0.6084p P=3.12u
R$252 \$I612 \$1 ptap1 A=0.6084p P=3.12u
R$253 \$I613 \$1 ptap1 A=0.6084p P=3.12u
R$254 \$I614 \$1 ptap1 A=0.6084p P=3.12u
R$255 \$I615 \$1 ptap1 A=0.6084p P=3.12u
R$256 \$I616 \$1 ptap1 A=0.6084p P=3.12u
R$257 \$I617 \$1 ptap1 A=0.6084p P=3.12u
R$258 \$I618 \$1 ptap1 A=0.6084p P=3.12u
R$259 \$I619 \$1 ptap1 A=0.6084p P=3.12u
R$260 \$I620 \$1 ptap1 A=0.6084p P=3.12u
R$261 \$I621 \$1 ptap1 A=0.6084p P=3.12u
R$262 \$I622 \$1 ptap1 A=0.6084p P=3.12u
R$263 \$I623 \$1 ptap1 A=0.6084p P=3.12u
R$264 \$I624 \$1 ptap1 A=0.6084p P=3.12u
R$265 \$I625 \$1 ptap1 A=0.6084p P=3.12u
R$266 \$I626 \$1 ptap1 A=0.6084p P=3.12u
R$267 \$I627 \$1 ptap1 A=0.6084p P=3.12u
R$268 \$I628 \$1 ptap1 A=0.6084p P=3.12u
R$269 \$I629 \$1 ptap1 A=0.6084p P=3.12u
R$270 \$I630 \$1 ptap1 A=0.6084p P=3.12u
R$271 \$I631 \$1 ptap1 A=0.6084p P=3.12u
R$272 \$I632 \$1 ptap1 A=0.6084p P=3.12u
R$273 \$I633 \$1 ptap1 A=0.6084p P=3.12u
R$274 \$I634 \$1 ptap1 A=0.6084p P=3.12u
R$275 \$I635 \$1 ptap1 A=0.6084p P=3.12u
R$276 \$I636 \$1 ptap1 A=0.6084p P=3.12u
R$277 \$I637 \$1 ptap1 A=0.6084p P=3.12u
R$278 \$I638 \$1 ptap1 A=0.6084p P=3.12u
R$279 \$I639 \$1 ptap1 A=0.6084p P=3.12u
R$280 \$I640 \$1 ptap1 A=0.6084p P=3.12u
R$281 \$I641 \$1 ptap1 A=0.6084p P=3.12u
R$282 \$I642 \$1 ptap1 A=0.6084p P=3.12u
R$283 \$I643 \$1 ptap1 A=0.6084p P=3.12u
R$284 \$I644 \$1 ptap1 A=0.6084p P=3.12u
R$285 \$I645 \$1 ptap1 A=0.6084p P=3.12u
R$286 \$I646 \$1 ptap1 A=0.6084p P=3.12u
R$287 \$I647 \$1 ptap1 A=0.6084p P=3.12u
R$288 \$I648 \$1 ptap1 A=0.6084p P=3.12u
R$289 \$I649 \$1 ptap1 A=0.6084p P=3.12u
R$290 \$I650 \$1 ptap1 A=0.6084p P=3.12u
R$291 \$I651 \$1 ptap1 A=0.6084p P=3.12u
R$292 \$I652 \$1 ptap1 A=0.6084p P=3.12u
R$293 \$I653 \$1 ptap1 A=0.6084p P=3.12u
R$294 \$I654 \$1 ptap1 A=0.6084p P=3.12u
R$295 \$I655 \$1 ptap1 A=0.6084p P=3.12u
R$296 \$I656 \$1 ptap1 A=0.6084p P=3.12u
R$297 \$I657 \$1 ptap1 A=0.6084p P=3.12u
R$298 \$I658 \$1 ptap1 A=0.6084p P=3.12u
R$299 \$I659 \$1 ptap1 A=0.6084p P=3.12u
R$300 \$I660 \$1 ptap1 A=0.6084p P=3.12u
R$301 \$I661 \$1 ptap1 A=0.6084p P=3.12u
R$302 \$I662 \$1 ptap1 A=0.6084p P=3.12u
R$303 \$I663 \$1 ptap1 A=0.6084p P=3.12u
R$304 \$I664 \$1 ptap1 A=0.6084p P=3.12u
R$305 \$I665 \$1 ptap1 A=0.6084p P=3.12u
R$306 \$I666 \$1 ptap1 A=0.6084p P=3.12u
R$307 \$I667 \$1 ptap1 A=0.6084p P=3.12u
R$308 \$I668 \$1 ptap1 A=0.6084p P=3.12u
R$309 \$I669 \$1 ptap1 A=0.6084p P=3.12u
R$310 \$I670 \$1 ptap1 A=0.6084p P=3.12u
R$311 \$I671 \$1 ptap1 A=0.6084p P=3.12u
R$312 \$I672 \$1 ptap1 A=0.6084p P=3.12u
R$313 \$I673 \$1 ptap1 A=0.6084p P=3.12u
R$314 \$I674 \$1 ptap1 A=0.6084p P=3.12u
R$315 \$I675 \$1 ptap1 A=0.6084p P=3.12u
R$316 \$I676 \$1 ptap1 A=0.6084p P=3.12u
R$317 \$I677 \$1 ptap1 A=0.6084p P=3.12u
R$318 \$I678 \$1 ptap1 A=0.6084p P=3.12u
R$319 \$I679 \$1 ptap1 A=0.6084p P=3.12u
R$320 \$I680 \$1 ptap1 A=0.6084p P=3.12u
R$321 \$I681 \$1 ptap1 A=0.6084p P=3.12u
R$322 \$I682 \$1 ptap1 A=0.6084p P=3.12u
R$323 \$I683 \$1 ptap1 A=0.6084p P=3.12u
R$324 \$I684 \$1 ptap1 A=0.6084p P=3.12u
R$325 \$I685 \$1 ptap1 A=0.6084p P=3.12u
R$326 \$I686 \$1 ptap1 A=0.6084p P=3.12u
R$327 \$I687 \$1 ptap1 A=0.6084p P=3.12u
R$328 \$I688 \$1 ptap1 A=0.6084p P=3.12u
R$329 \$I689 \$1 ptap1 A=0.6084p P=3.12u
R$330 \$I690 \$1 ptap1 A=0.6084p P=3.12u
R$331 \$I691 \$1 ptap1 A=0.6084p P=3.12u
R$332 \$I692 \$1 ptap1 A=0.6084p P=3.12u
R$333 \$I693 \$1 ptap1 A=0.6084p P=3.12u
R$334 \$I694 \$1 ptap1 A=0.6084p P=3.12u
R$335 \$I695 \$1 ptap1 A=0.6084p P=3.12u
R$336 \$I696 \$1 ptap1 A=0.6084p P=3.12u
R$337 \$I697 \$1 ptap1 A=0.6084p P=3.12u
R$338 \$I698 \$1 ptap1 A=0.6084p P=3.12u
R$339 \$I699 \$1 ptap1 A=0.6084p P=3.12u
R$340 \$I700 \$1 ptap1 A=0.6084p P=3.12u
R$341 \$I701 \$1 ptap1 A=0.6084p P=3.12u
R$342 \$I702 \$1 ptap1 A=0.6084p P=3.12u
R$343 \$I703 \$1 ptap1 A=0.6084p P=3.12u
R$344 \$I704 \$1 ptap1 A=0.6084p P=3.12u
R$345 \$I705 \$1 ptap1 A=0.6084p P=3.12u
R$346 \$I706 \$1 ptap1 A=0.6084p P=3.12u
R$347 \$I707 \$1 ptap1 A=0.6084p P=3.12u
R$348 \$I708 \$1 ptap1 A=0.6084p P=3.12u
R$349 \$I709 \$1 ptap1 A=0.6084p P=3.12u
R$350 \$I710 \$1 ptap1 A=0.6084p P=3.12u
R$351 \$I711 \$1 ptap1 A=0.6084p P=3.12u
R$352 \$I712 \$1 ptap1 A=0.6084p P=3.12u
R$353 \$I713 \$1 ptap1 A=0.6084p P=3.12u
R$354 \$I714 \$1 ptap1 A=0.6084p P=3.12u
R$355 \$I715 \$1 ptap1 A=0.6084p P=3.12u
R$356 \$I716 \$1 ptap1 A=0.6084p P=3.12u
R$357 \$I717 \$1 ptap1 A=0.6084p P=3.12u
R$358 \$I718 \$1 ptap1 A=0.6084p P=3.12u
R$359 \$I719 \$1 ptap1 A=0.6084p P=3.12u
R$360 \$I720 \$1 ptap1 A=0.6084p P=3.12u
M$361 \$I360 \$2 \$3 \$1 sg13_lv_nmos L=1u W=246.75u AS=83.895p AD=83.895p
+ PS=510.5u PD=510.5u rfmode=0
M$386 \$I721 \$2 \$3 \$1 sg13_lv_nmos L=1u W=246.75u AS=83.895p AD=83.895p
+ PS=510.5u PD=510.5u rfmode=0
M$411 \$I722 \$2 \$3 \$1 sg13_lv_nmos L=1u W=246.75u AS=83.895p AD=83.895p
+ PS=510.5u PD=510.5u rfmode=0
.ENDS vga_dut
