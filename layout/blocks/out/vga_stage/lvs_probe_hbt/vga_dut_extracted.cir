* Extracted by KLayout with SG13G2 LVS runset on : 20/08/2026 14:26

.SUBCKT vga_dut
Q$1 \$I671 \$I672 \$1 \$1 npn13G2 we=70n le=900n Nx=1 m=1
Q$2 \$I673 \$I674 \$1 \$1 npn13G2 we=70n le=900n Nx=1 m=1
Q$3 \$I675 \$I676 \$1 \$1 npn13G2 we=70n le=900n Nx=1 m=1
Q$4 \$I677 \$I678 \$1 \$1 npn13G2 we=70n le=900n Nx=1 m=1
M$5 \$1 \$11 \$1 \$1 sg13_lv_nmos L=1u W=246.75u AS=83.895p AD=83.895p
+ PS=510.5u PD=510.5u rfmode=0
M$30 \$1 \$1 \$1 \$1 sg13_lv_nmos L=1u W=493.5u AS=167.79p AD=167.79p PS=1021u
+ PD=1021u rfmode=0
M$55 \$1 \$1 \$1 \$1 sg13_lv_nmos L=0.5u W=600u AS=204p AD=204p PS=1240.8u
+ PD=1240.8u rfmode=0
M$95 \$1 \$7 \$1 \$1 sg13_lv_nmos L=0.5u W=200u AS=68p AD=68p PS=413.6u
+ PD=413.6u rfmode=0
.ENDS vga_dut
