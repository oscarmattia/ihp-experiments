* Extracted by KLayout with SG13G2 LVS runset on : 20/08/2026 12:37

.SUBCKT vga_dut vss mgate
M$1 mgate mgate vss vss sg13_lv_nmos L=1u W=246.75u AS=83.895p AD=83.895p
+ PS=510.5u PD=510.5u rfmode=0
M$26 \$4 \$10 \$4 vss sg13_lv_nmos L=0.5u W=400u AS=136p AD=136p PS=827.2u
+ PD=827.2u rfmode=0
M$46 \$4 \$3 \$4 vss sg13_lv_nmos L=0.5u W=400u AS=136p AD=136p PS=827.2u
+ PD=827.2u rfmode=0
M$106 \$4 \$10 vss vss sg13_lv_nmos L=1u W=246.75u AS=83.895p AD=83.895p
+ PS=510.5u PD=510.5u rfmode=0
M$131 \$4 \$9 vss vss sg13_lv_nmos L=1u W=246.75u AS=83.895p AD=83.895p
+ PS=510.5u PD=510.5u rfmode=0
.ENDS vga_dut
