* Extracted by KLayout with SG13G2 LVS runset on : 20/08/2026 14:29

.SUBCKT vga_dut mgate vss
M$1 mgate \$13 vss vss sg13_lv_nmos L=1u W=246.75u AS=83.895p AD=83.895p
+ PS=510.5u PD=510.5u rfmode=0
M$26 mgate mgate vss vss sg13_lv_nmos L=1u W=246.75u AS=83.895p AD=83.895p
+ PS=510.5u PD=510.5u rfmode=0
M$51 mgate mgate \$I660 vss sg13_lv_nmos L=0.5u W=200u AS=68p AD=68p PS=413.6u
+ PD=413.6u rfmode=0
M$71 \$17 \$4 vss vss sg13_lv_nmos L=0.5u W=200u AS=68p AD=68p PS=413.6u
+ PD=413.6u rfmode=0
M$91 \$17 \$7 \$I661 vss sg13_lv_nmos L=0.5u W=200u AS=68p AD=68p PS=413.6u
+ PD=413.6u rfmode=0
M$111 \$17 mgate vss vss sg13_lv_nmos L=1u W=246.75u AS=83.895p AD=83.895p
+ PS=510.5u PD=510.5u rfmode=0
M$136 mgate \$4 vss vss sg13_lv_nmos L=0.5u W=200u AS=68p AD=68p PS=413.6u
+ PD=413.6u rfmode=0
.ENDS vga_dut
