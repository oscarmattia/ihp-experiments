* nmos_tail_pair — generated from DeviceSpecs; do not edit by hand
.SUBCKT nmos_tail_pair e1 e2 mgate vss
M1 e1 mgate vss sub sg13_lv_nmos w=9.72u l=1u ng=1 m=1
M2 e1 mgate vss sub sg13_lv_nmos w=9.72u l=1u ng=1 m=1
M3 e1 mgate vss sub sg13_lv_nmos w=9.72u l=1u ng=1 m=1
M4 e1 mgate vss sub sg13_lv_nmos w=9.72u l=1u ng=1 m=1
M5 e1 mgate vss sub sg13_lv_nmos w=9.72u l=1u ng=1 m=1
M6 e1 mgate vss sub sg13_lv_nmos w=9.72u l=1u ng=1 m=1
M7 e1 mgate vss sub sg13_lv_nmos w=9.72u l=1u ng=1 m=1
M8 e1 mgate vss sub sg13_lv_nmos w=9.72u l=1u ng=1 m=1
M9 e1 mgate vss sub sg13_lv_nmos w=9.72u l=1u ng=1 m=1
M10 e1 mgate vss sub sg13_lv_nmos w=9.72u l=1u ng=1 m=1
M11 e1 mgate vss sub sg13_lv_nmos w=9.72u l=1u ng=1 m=1
M12 e1 mgate vss sub sg13_lv_nmos w=9.72u l=1u ng=1 m=1
M13 e1 mgate vss sub sg13_lv_nmos w=9.72u l=1u ng=1 m=1
M14 e1 mgate vss sub sg13_lv_nmos w=9.72u l=1u ng=1 m=1
M15 e1 mgate vss sub sg13_lv_nmos w=9.72u l=1u ng=1 m=1
M16 e1 mgate vss sub sg13_lv_nmos w=9.72u l=1u ng=1 m=1
M17 e1 mgate vss sub sg13_lv_nmos w=9.72u l=1u ng=1 m=1
M18 e1 mgate vss sub sg13_lv_nmos w=9.72u l=1u ng=1 m=1
M19 e1 mgate vss sub sg13_lv_nmos w=9.72u l=1u ng=1 m=1
M20 e1 mgate vss sub sg13_lv_nmos w=9.72u l=1u ng=1 m=1
M21 e1 mgate vss sub sg13_lv_nmos w=9.72u l=1u ng=1 m=1
M22 e1 mgate vss sub sg13_lv_nmos w=9.72u l=1u ng=1 m=1
M23 e1 mgate vss sub sg13_lv_nmos w=9.72u l=1u ng=1 m=1
M24 e1 mgate vss sub sg13_lv_nmos w=9.72u l=1u ng=1 m=1
M25 e1 mgate vss sub sg13_lv_nmos w=9.72u l=1u ng=1 m=1
M26 e2 mgate vss sub sg13_lv_nmos w=9.72u l=1u ng=1 m=1
M27 e2 mgate vss sub sg13_lv_nmos w=9.72u l=1u ng=1 m=1
M28 e2 mgate vss sub sg13_lv_nmos w=9.72u l=1u ng=1 m=1
M29 e2 mgate vss sub sg13_lv_nmos w=9.72u l=1u ng=1 m=1
M30 e2 mgate vss sub sg13_lv_nmos w=9.72u l=1u ng=1 m=1
M31 e2 mgate vss sub sg13_lv_nmos w=9.72u l=1u ng=1 m=1
M32 e2 mgate vss sub sg13_lv_nmos w=9.72u l=1u ng=1 m=1
M33 e2 mgate vss sub sg13_lv_nmos w=9.72u l=1u ng=1 m=1
M34 e2 mgate vss sub sg13_lv_nmos w=9.72u l=1u ng=1 m=1
M35 e2 mgate vss sub sg13_lv_nmos w=9.72u l=1u ng=1 m=1
M36 e2 mgate vss sub sg13_lv_nmos w=9.72u l=1u ng=1 m=1
M37 e2 mgate vss sub sg13_lv_nmos w=9.72u l=1u ng=1 m=1
M38 e2 mgate vss sub sg13_lv_nmos w=9.72u l=1u ng=1 m=1
M39 e2 mgate vss sub sg13_lv_nmos w=9.72u l=1u ng=1 m=1
M40 e2 mgate vss sub sg13_lv_nmos w=9.72u l=1u ng=1 m=1
M41 e2 mgate vss sub sg13_lv_nmos w=9.72u l=1u ng=1 m=1
M42 e2 mgate vss sub sg13_lv_nmos w=9.72u l=1u ng=1 m=1
M43 e2 mgate vss sub sg13_lv_nmos w=9.72u l=1u ng=1 m=1
M44 e2 mgate vss sub sg13_lv_nmos w=9.72u l=1u ng=1 m=1
M45 e2 mgate vss sub sg13_lv_nmos w=9.72u l=1u ng=1 m=1
M46 e2 mgate vss sub sg13_lv_nmos w=9.72u l=1u ng=1 m=1
M47 e2 mgate vss sub sg13_lv_nmos w=9.72u l=1u ng=1 m=1
M48 e2 mgate vss sub sg13_lv_nmos w=9.72u l=1u ng=1 m=1
M49 e2 mgate vss sub sg13_lv_nmos w=9.72u l=1u ng=1 m=1
M50 e2 mgate vss sub sg13_lv_nmos w=9.72u l=1u ng=1 m=1
.ENDS nmos_tail_pair
