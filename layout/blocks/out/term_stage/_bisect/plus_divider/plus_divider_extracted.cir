* Extracted by KLayout with SG13G2 LVS runset on : 20/08/2026 14:27

.SUBCKT term_dut inn|inp|vdd|vss|vtt
C$1 inn|inp|vdd|vss|vtt \$30 cap_cmim w=20u l=20u A=400p P=80u m=1
R$2 inn|inp|vdd|vss|vtt \$30 inn|inp|vdd|vss|vtt rppd w=1u l=5u ps=0u b=0 m=1
R$3 \$26 inn|inp|vdd|vss|vtt inn|inp|vdd|vss|vtt rppd w=1u l=0.5u ps=0u b=0 m=1
R$4 inn|inp|vdd|vss|vtt inn|inp|vdd|vss|vtt inn|inp|vdd|vss|vtt rsil w=0.5u
+ l=2.35u ps=0u b=0 m=2
D$6 inn|inp|vdd|vss|vtt inn|inp|vdd|vss|vtt inn|inp|vdd|vss|vtt diodevss_2kv m=2
D$7 inn|inp|vdd|vss|vtt inn|inp|vdd|vss|vtt inn|inp|vdd|vss|vtt diodevdd_2kv m=2
.ENDS term_dut
