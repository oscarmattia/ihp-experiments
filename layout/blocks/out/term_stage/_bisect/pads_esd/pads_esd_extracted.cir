* Extracted by KLayout with SG13G2 LVS runset on : 20/08/2026 14:27

.SUBCKT term_dut vdd|vss inn|inp
D$1 vdd|vss vdd|vss inn|inp diodevss_2kv m=2
D$2 vdd|vss vdd|vss inn|inp diodevdd_2kv m=2
.ENDS term_dut
