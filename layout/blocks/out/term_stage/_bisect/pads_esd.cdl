* term_dut — generated from DeviceSpecs; do not edit by hand
.SUBCKT term_dut inp inn vdd vss
D1 vdd inp vss diodevdd_2kv m=1
D2 vdd inp vss diodevss_2kv m=1
D3 vdd inn vss diodevdd_2kv m=1
D4 vdd inn vss diodevss_2kv m=1
.ENDS term_dut
