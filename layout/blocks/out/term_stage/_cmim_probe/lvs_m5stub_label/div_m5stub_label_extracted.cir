* Extracted by KLayout with SG13G2 LVS runset on : 20/08/2026 11:12

.SUBCKT probe vss
C$1 \$I4 vss cap_cmim w=20u l=20u A=400p P=80u m=1
R$2 \$3 \$I5 \$2 rppd w=1u l=0.5u ps=0u b=0 m=1
R$3 \$I6 \$4 \$2 rppd w=1u l=5u ps=0u b=0 m=1
.ENDS probe
