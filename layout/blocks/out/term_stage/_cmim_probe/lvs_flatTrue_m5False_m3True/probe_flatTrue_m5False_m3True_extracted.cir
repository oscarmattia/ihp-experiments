* Extracted by KLayout with SG13G2 LVS runset on : 20/08/2026 11:09

.SUBCKT probe vss
R$1 \$2 vss \$1 rppd w=1u l=5u ps=0u b=0 m=1
C$2 \$3 \$5 cap_cmim w=20u l=20u A=400p P=80u m=1
.ENDS probe
