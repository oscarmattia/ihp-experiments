* driver_dut_core — extracted core; do not edit by hand
.subckt driver_dut_core outp outn inp inn vdd vss mgate nlp1 nlp2 em
XQ2 outn inn em vss npn13G2 we=70n le=900n nx=2
X$2 outn nlp2 vss rsil w=0.5u l=2.35u ps=0u m=1
XQ1 outp inp em vss npn13G2 we=70n le=900n nx=2
X$4 outp nlp1 vss rsil w=0.5u l=2.35u ps=0u m=1
Xesd_vdd_p vdd outp vss diodevdd_2kv m=1
Xesd_vss_p vdd outp vss diodevss_2kv m=1
Xesd_vdd_n vdd outn vss diodevdd_2kv m=1
Xesd_vss_n vdd outn vss diodevss_2kv m=1
Xclamp vdd vss nmoscl_2 m=1 pre_layout=0
Xmdiode mgate mgate vss vss sg13_lv_nmos l=1u w=391.6u as=133.144p ad=133.144p ps=810.4u pd=810.4u rfmode=0 pre_layout=0
Xtail em mgate vss vss sg13_lv_nmos l=1u w=782.89u as=266.1826p ad=266.1826p ps=1619.5u pd=1619.5u rfmode=0 pre_layout=0
.ends driver_dut_core
