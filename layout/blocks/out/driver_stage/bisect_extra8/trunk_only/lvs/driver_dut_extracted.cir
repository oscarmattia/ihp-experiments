* Extracted by KLayout with SG13G2 LVS runset on : 20/08/2026 17:10

.SUBCKT driver_dut vss inp inn vdd mgate em outp outn nlp1 nlp2
L$13 nlp2 vdd vss inductor w=4u s=2.1u d=40u nr_r=1
L$14 nlp1 vdd vss inductor w=4u s=2.1u d=40u nr_r=1
R$15 outn nlp2 vss rsil w=0.5u l=2.35u ps=0u b=0 m=1
Q$16 outn inn em vss npn13G2 we=70n le=900n Nx=2 m=1
R$17 outp nlp1 vss rsil w=0.5u l=2.35u ps=0u b=0 m=1
Q$18 outp inp em vss npn13G2 we=70n le=900n Nx=2 m=1
D$19 vss vss vss diodevdd_2kv m=2
M$21 mgate mgate vss vss sg13_lv_nmos L=1u W=392u AS=133.28p AD=133.28p
+ PS=811.2u PD=811.2u rfmode=0
M$61 em mgate vss vss sg13_lv_nmos L=1u W=783.68u AS=266.4512p AD=266.4512p
+ PS=1621.08u PD=1621.08u rfmode=0
.ENDS driver_dut
