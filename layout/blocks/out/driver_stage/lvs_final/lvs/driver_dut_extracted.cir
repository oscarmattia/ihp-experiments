* Extracted by KLayout with SG13G2 LVS runset on : 20/08/2026 10:23

.SUBCKT driver_dut outn|outp|vdd|vss inp inn mgate em nlp1 nlp2
R$1 outn|outp|vdd|vss nlp2 outn|outp|vdd|vss rsil w=0.5u l=2.35u ps=0u b=0 m=1
Q$2 outn|outp|vdd|vss inn em outn|outp|vdd|vss npn13G2 we=70n le=900n Nx=2 m=1
R$3 outn|outp|vdd|vss nlp1 outn|outp|vdd|vss rsil w=0.5u l=2.35u ps=0u b=0 m=1
Q$4 outn|outp|vdd|vss inp em outn|outp|vdd|vss npn13G2 we=70n le=900n Nx=2 m=1
D$5 outn|outp|vdd|vss outn|outp|vdd|vss outn|outp|vdd|vss diodevss_2kv m=2
D$6 outn|outp|vdd|vss outn|outp|vdd|vss outn|outp|vdd|vss diodevdd_2kv m=2
D$9 outn|outp|vdd|vss outn|outp|vdd|vss nmoscl_2 m=1
L$10 outn|outp|vdd|vss nlp2 outn|outp|vdd|vss inductor w=4u s=2.1u d=40u nr_r=1
L$11 outn|outp|vdd|vss nlp1 outn|outp|vdd|vss inductor w=4u s=2.1u d=40u nr_r=1
M$12 mgate mgate outn|outp|vdd|vss outn|outp|vdd|vss sg13_lv_nmos L=1u W=392u
+ AS=133.28p AD=133.28p PS=811.2u PD=811.2u rfmode=0
M$52 em mgate outn|outp|vdd|vss outn|outp|vdd|vss sg13_lv_nmos L=1u W=783.68u
+ AS=266.4512p AD=266.4512p PS=1621.08u PD=1621.08u rfmode=0
.ENDS driver_dut
