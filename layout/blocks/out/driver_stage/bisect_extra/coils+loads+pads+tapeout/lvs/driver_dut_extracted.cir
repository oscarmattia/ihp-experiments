* Extracted by KLayout with SG13G2 LVS runset on : 20/08/2026 15:37

.SUBCKT driver_dut vss inp inn outn|outp|vdd|vss mgate em outp nlp1 outn nlp2
L$1 nlp2 outn|outp|vdd|vss vss inductor w=2u s=2.1u d=44.37u nr_r=1
L$2 nlp1 outn|outp|vdd|vss vss inductor w=2u s=2.1u d=44.37u nr_r=1
R$3 outn nlp2 vss rsil w=0.5u l=2.35u ps=0u b=0 m=1
Q$4 outn inn em vss npn13G2 we=70n le=900n Nx=2 m=1
R$5 outp nlp1 vss rsil w=0.5u l=2.35u ps=0u b=0 m=1
Q$6 outp inp em vss npn13G2 we=70n le=900n Nx=2 m=1
D$7 \$296 \$296 nmoscl_2 m=1
M$8 mgate \$21 vss vss sg13_lv_nmos L=1u W=392u AS=133.28p AD=133.28p PS=811.2u
+ PD=811.2u rfmode=0
M$48 em \$94 vss vss sg13_lv_nmos L=1u W=783.68u AS=266.4512p AD=266.4512p
+ PS=1621.08u PD=1621.08u rfmode=0
.ENDS driver_dut
