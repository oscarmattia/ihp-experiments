* Extracted by KLayout with SG13G2 LVS runset on : 20/08/2026 10:20

.SUBCKT driver_dut vss inp inn vdd mgate em nlp1 nlp2 outn outp
R$1 \$I572 nlp2 vss rsil w=0.5u l=2.35u ps=0u b=0 m=1
Q$2 outn inn em vss npn13G2 we=70n le=900n Nx=2 m=1
R$3 \$I573 nlp1 vss rsil w=0.5u l=2.35u ps=0u b=0 m=1
Q$4 outp inp em vss npn13G2 we=70n le=900n Nx=2 m=1
D$5 \$I574 vss \$I575 diodevss_2kv m=1
D$6 vss vdd \$I576 diodevdd_2kv m=1
D$7 \$I577 vss \$I578 diodevss_2kv m=1
D$8 vss vdd \$I579 diodevdd_2kv m=1
D$9 vss vdd nmoscl_2 m=1
L$10 vdd nlp2 vss inductor w=4u s=2.1u d=40u nr_r=1
L$11 vdd nlp1 vss inductor w=4u s=2.1u d=40u nr_r=1
M$12 mgate mgate vss vss sg13_lv_nmos L=1u W=392u AS=133.28p AD=133.28p
+ PS=811.2u PD=811.2u rfmode=0
M$52 em mgate vss vss sg13_lv_nmos L=1u W=783.68u AS=266.4512p AD=266.4512p
+ PS=1621.08u PD=1621.08u rfmode=0
.ENDS driver_dut
