* Extracted by KLayout with SG13G2 LVS runset on : 20/08/2026 19:08

.SUBCKT driver_dut em|inn|inp|mgate|outn|outp|vdd|vss
D$2 em|inn|inp|mgate|outn|outp|vdd|vss em|inn|inp|mgate|outn|outp|vdd|vss
+ \$I1000 diodevss_2kv m=0.3
D$3 em|inn|inp|mgate|outn|outp|vdd|vss em|inn|inp|mgate|outn|outp|vdd|vss \$21
+ diodevss_4kv m=1
M$4 em|inn|inp|mgate|outn|outp|vdd|vss em|inn|inp|mgate|outn|outp|vdd|vss
+ em|inn|inp|mgate|outn|outp|vdd|vss em|inn|inp|mgate|outn|outp|vdd|vss
+ sg13_lv_nmos L=1u W=988.4u AS=336.056p AD=336.056p PS=2044.8u PD=2044.8u
+ rfmode=0
.ENDS driver_dut
