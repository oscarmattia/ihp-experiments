* driver_dut — generated from DeviceSpecs; do not edit by hand
.SUBCKT driver_dut outp outn inp inn vdd vss mgate
M1 mgate mgate vss vss sg13_lv_nmos w=392u l=1u ng=1 m=1
M2 em mgate vss vss sg13_lv_nmos w=783.68u l=1u ng=1 m=1
Q1 outp inp em vss npn13G2 le=0.9u we=0.07u Nx=2 m=1
Q2 outn inn em vss npn13G2 le=0.9u we=0.07u Nx=2 m=1
D1 vdd outp vss diodevdd_2kv m=1
D2 vdd outp vss diodevss_2kv m=1
D3 vdd outn vss diodevdd_2kv m=1
D4 vdd outn vss diodevss_2kv m=1
.ENDS driver_dut
