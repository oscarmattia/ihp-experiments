* driver_dut — generated from DeviceSpecs; do not edit by hand
.SUBCKT driver_dut outp outn inp inn vdd vss mgate
M1 mgate mgate vss vss sg13_lv_nmos w=392u l=1u ng=1 m=1
M2 em mgate vss vss sg13_lv_nmos w=784.075u l=1u ng=1 m=1
Q1 outp inp em vss npn13G2 le=0.9u we=0.07u Nx=2 m=1
Q2 outn inn em vss npn13G2 le=0.9u we=0.07u Nx=2 m=1
R1 outp nlp1 vss rsil m=1 l=2.35u w=0.5u
R2 outn nlp2 vss rsil m=1 l=2.35u w=0.5u
L1 vdd nlp1 vss inductor w=4u s=2.1u d=40u nr_r=1
L2 vdd nlp2 vss inductor w=4u s=2.1u d=40u nr_r=1
D1 vdd vss nmoscl_2 m=1
.ENDS driver_dut
