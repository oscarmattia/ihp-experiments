* Extracted by KLayout with SG13G2 LVS runset on : 20/08/2026 19:07

.SUBCKT driver_dut mgate em vss inp inn vdd outp outn
Q$1 outn inn em vss npn13G2 we=70n le=900n Nx=2 m=1
Q$2 outp inp em vss npn13G2 we=70n le=900n Nx=2 m=1
D$3 \$I568 vss \$I569 diodevss_2kv m=1
D$4 vss vdd \$I570 diodevdd_2kv m=1
D$5 \$I571 vss \$I572 diodevss_2kv m=1
D$6 vss vdd \$I573 diodevdd_2kv m=1
M$7 mgate mgate vss vss sg13_lv_nmos L=1u W=392u AS=133.28p AD=133.28p
+ PS=811.2u PD=811.2u rfmode=0
M$47 em mgate vss vss sg13_lv_nmos L=1u W=783.68u AS=266.4512p AD=266.4512p
+ PS=1621.08u PD=1621.08u rfmode=0
.ENDS driver_dut
