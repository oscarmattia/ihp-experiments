* Extracted by KLayout with SG13G2 LVS runset on : 20/08/2026 16:48

.SUBCKT driver_dut mgate outp outn nlp1 nlp2 em vss inp inn vdd
L$1 nlp2 vdd vss inductor w=4u s=2.1u d=40u nr_r=1
L$2 nlp1 vdd vss inductor w=4u s=2.1u d=40u nr_r=1
Q$3 outn inn em vss npn13G2 we=70n le=900n Nx=2 m=1
R$4 outn nlp2 vss rsil w=0.5u l=2.35u ps=0u b=0 m=1
Q$5 outp inp em vss npn13G2 we=70n le=900n Nx=2 m=1
R$6 outp nlp1 vss rsil w=0.5u l=2.35u ps=0u b=0 m=1
D$7 vdd vdd nmoscl_2 m=1
M$8 mgate mgate vss vss sg13_lv_nmos L=1u W=392u AS=133.28p AD=133.28p
+ PS=811.2u PD=811.2u rfmode=0
M$48 em mgate vss vss sg13_lv_nmos L=1u W=783.68u AS=266.4512p AD=266.4512p
+ PS=1621.08u PD=1621.08u rfmode=0
.ENDS driver_dut
