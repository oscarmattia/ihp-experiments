* rsil_term — generated from DeviceSpec; do not edit by hand
.SUBCKT rsil_term PLUS MINUS
R1 PLUS MINUS sub rsil m=1 l=2.35u w=0.5u
.ENDS rsil_term
