* nmos_tail — generated from DeviceSpec; do not edit by hand
.SUBCKT nmos_tail D G S
M1 D G S sub sg13_lv_nmos w=243u l=1u ng=100 m=1
.ENDS nmos_tail
