* npn13G2_driver — generated from DeviceSpec; do not edit by hand
.SUBCKT npn13G2_driver C B E
Q1 C B E sub npn13G2 le=0.9u we=0.07u Nx=2 m=1
.ENDS npn13G2_driver
