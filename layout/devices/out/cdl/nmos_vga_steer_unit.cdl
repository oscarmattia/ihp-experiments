* nmos_vga_steer_unit — generated from DeviceSpec; do not edit by hand
.SUBCKT nmos_vga_steer_unit D G S
M1 D G S sub sg13_lv_nmos w=10u l=0.5u ng=1 m=1
.ENDS nmos_vga_steer_unit
