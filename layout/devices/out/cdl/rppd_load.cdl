* rppd_load — generated from DeviceSpec; do not edit by hand
.SUBCKT rppd_load PLUS MINUS
R1 PLUS MINUS sub rppd m=1 l=1.4u w=5u
.ENDS rppd_load
