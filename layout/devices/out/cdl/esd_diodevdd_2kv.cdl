* esd_diodevdd_2kv — generated from DeviceSpec; do not edit by hand
.SUBCKT esd_diodevdd_2kv VDD PAD VSS
D1 VDD PAD VSS diodevdd_2kv m=1
.ENDS esd_diodevdd_2kv
