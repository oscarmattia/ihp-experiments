* AC differential testbench — vod/vid
.include params.inc
.include {DUT_CIR}

Vdd vdd 0 dc {VDD}
XU1 outp outn inp inn vdd ctle_dut

Vp inp 0 dc {VBASE} ac 0.5 0
Vn inn 0 dc {VBASE} ac 0.5 180

Cload_p outp 0 {CL}
Cload_n outn 0 {CL}

.options gmin=1e-18 abstol=1e-15 reltol=1e-3
.nodeset v(xu1.mgate)={MOS_VGS} v(xu1.em)=0.28 v(xu1.e1)=0.28 v(xu1.e2)=0.28

.control
save v(outp) v(outn) v(inp) v(inn)
ac dec 200 1e6 300e9
set wr_singlescale
wrdata ac_diff.raw frequency vm(outp) vp(outp) vm(outn) vp(outn) vm(inp) vp(inp) vm(inn) vp(inn)
.endc
.end
