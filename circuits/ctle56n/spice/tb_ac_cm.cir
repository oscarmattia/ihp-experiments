* AC common-mode testbench — voc/vic (CMRR = Adm/Acm)
.include params.inc
.include {DUT_CIR}

Vdd vdd 0 dc {VDD}
XU1 {DUT_PORTS} {DUT_NAME}
{DUT_BIAS}
Vp inp 0 dc {VBASE} ac 1
Vn inn 0 dc {VBASE} ac 1

Cload_p outp 0 {CL_TB}
Cload_n outn 0 {CL_TB}

.options gmin=1e-18 abstol=1e-15 reltol=1e-3
{DUT_NODESET}

.control
save v(outp) v(outn) v(inp) v(inn)
ac dec 200 1e6 300e9
set wr_singlescale
wrdata ac_cm.raw frequency vm(outp) vp(outp) vm(outn) vp(outn) vm(inp) vp(inp) vm(inn) vp(inn)
.endc
.end
