* DC OP testbench — 56G CML CTLE
.include params.inc
.include {DUT_CIR}

Vdd vdd 0 dc {VDD}
XU1 {DUT_PORTS} {DUT_NAME}
{DUT_BIAS}
Vp inp 0 dc {VBASE}
Vn inn 0 dc {VBASE}

.options gmin=1e-18 abstol=1e-15 reltol=1e-3
{DUT_NODESET}

.control
{DC_SAVE_LINES}
op
echo "--- DC operating point ---"
{DC_PRINT_LINES}
.endc
.end
