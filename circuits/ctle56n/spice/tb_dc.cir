* DC OP testbench — 56G CML CTLE
.include params.inc
.include {DUT_CIR}

Vdd vdd 0 dc {VDD}
XU1 outp outn inp inn vdd ctle_dut

Vp inp 0 dc {VBASE}
Vn inn 0 dc {VBASE}

.options gmin=1e-18 abstol=1e-15 reltol=1e-3
.nodeset v(xu1.mgate)={MOS_VGS} v(xu1.em)=0.28 v(xu1.e1)=0.28 v(xu1.e2)=0.28

.control
save v(outp) v(outn) v(inp) v(inn) v(vdd)
save v(xu1.e1) v(xu1.e2) v(xu1.em) v(xu1.mgate)
save @q.xu1.xq1.qnpn13g2[ic] @q.xu1.xq2.qnpn13g2[ic]
save @n.xu1.xtail.nsg13_lv_nmos[ids] @n.xu1.xmdiode.nsg13_lv_nmos[ids]
op
echo "--- DC operating point ---"
print v(outp) v(outn) v(inp) v(inn) v(vdd)
print v(xu1.e1) v(xu1.e2) v(xu1.em) v(xu1.mgate)
print @q.xu1.xq1.qnpn13g2[ic] @q.xu1.xq2.qnpn13g2[ic]
print @n.xu1.xtail.nsg13_lv_nmos[ids] @n.xu1.xmdiode.nsg13_lv_nmos[ids]
.endc
.end
