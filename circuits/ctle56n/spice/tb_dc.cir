* DC OP testbench — 56G CML CTLE
.include params.inc
.include {DUT_CIR}

Vdd vdd 0 dc {VDD}
XU1 outp outn inp inn vdd {DUT_NAME}

Vp inp 0 dc {VBASE}
Vn inn 0 dc {VBASE}

.options gmin=1e-18 abstol=1e-15 reltol=1e-3
.nodeset v(xu1.mgate)={MOS_VGS} v(xu1.em)=0.28 v(xu1.e1)=0.28 v(xu1.e2)=0.28

.control
{DC_SAVE_LINES}
op
echo "--- DC operating point ---"
{DC_PRINT_LINES}
.endc
.end
