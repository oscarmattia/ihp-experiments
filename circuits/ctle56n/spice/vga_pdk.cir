* 56G CML VGA DUT — PDK rppd + EM shunt inductor, tail-current steering
*
* Devices only — see vga_ideal.cir header for port/bias contract and Rs removal.
.include '{IND_SHUNT_INC}'

.lib '{PDK_MODELS}/cornerHBT.lib' hbt_typ
.lib '{PDK_MODELS}/cornerMOSlv.lib' mos_tt
.lib '{PDK_MODELS}/cornerRES.lib' res_typ

.subckt vga_dut outp outn inp inn vicm steerp steern vdd vss mgate
Xl1 vdd nlp1 vss ind_shunt
Xrd1 nlp1 outp vss rppd w={RPPD_W} l={RPPD_L} m=1
Xl2 vdd nlp2 vss ind_shunt
Xrd2 nlp2 outn vss rppd w={RPPD_W} l={RPPD_L} m=1

XQ1 outp inp em vss npn13G2 Nx={Nx}
XQ2 outn inn em vss npn13G2 Nx={Nx}

XQd1 outp vicm ed1 vss npn13G2 Nx={Nx}
XQd2 outn vicm ed2 vss npn13G2 Nx={Nx}

XMdiode mgate mgate vss vss sg13_lv_nmos w={MOS_W_m} l={MOS_L_m} ng=1 m=1 rfmode=0

Xtail1 tx1 mgate vss vss sg13_lv_nmos w={MOS_W_m} l={MOS_L_m} ng=1 m=1 rfmode=0
Xps1 em steerp tx1 vss sg13_lv_nmos w={STEER_W_m} l={STEER_L_m} ng=1 m=1 rfmode=0
Xpd1 ed1 steern tx1 vss sg13_lv_nmos w={STEER_W_m} l={STEER_L_m} ng=1 m=1 rfmode=0

Xtail2 tx2 mgate vss vss sg13_lv_nmos w={MOS_W_m} l={MOS_L_m} ng=1 m=1 rfmode=0
Xps2 em steerp tx2 vss sg13_lv_nmos w={STEER_W_m} l={STEER_L_m} ng=1 m=1 rfmode=0
Xpd2 ed2 steern tx2 vss sg13_lv_nmos w={STEER_W_m} l={STEER_L_m} ng=1 m=1 rfmode=0
.ends vga_dut
