* Transient — 56G NRZ single-bit response (1 UI pulse, 100 mVpp,diff)
.include params.inc
.include {DUT_CIR}
.include sbr_stim.inc

Vdd vdd 0 dc {VDD}
XU1 {DUT_PORTS} {DUT_NAME}
{DUT_BIAS}
Cload_p outp 0 {CL_TB}
Cload_n outn 0 {CL_TB}

.options gmin=1e-18 abstol=1e-15 reltol=1e-3
{DUT_NODESET}

.control
save v(outp) v(outn) v(inp) v(inn)
save @q.xu1.xq1.qnpn13g2[ic] @q.xu1.xq2.qnpn13g2[ic]
save @n.xu1.xtail.nsg13_lv_nmos[ids] @n.xu1.xmdiode.nsg13_lv_nmos[ids]
tran 0.5p {TMAX} 0 1p
set wr_singlescale
wrdata sbr.raw time v(outp) v(outn) v(inp) v(inn)
.endc
.end
