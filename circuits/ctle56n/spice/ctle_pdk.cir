* 56G CML CTLE DUT — PDK rppd loads + ideal L and Cs
.include params.inc

.lib '{PDK_MODELS}/cornerHBT.lib' hbt_typ
.lib '{PDK_MODELS}/cornerMOSlv.lib' mos_tt
.lib '{PDK_MODELS}/cornerRES.lib' res_typ

.subckt ctle_dut outp outn inp inn vdd
L1 vdd nlp1 {LLOAD}
Xrd1 nlp1 outp 0 rppd w={RPPD_W} l={RPPD_L} m=1
L2 vdd nlp2 {LLOAD}
Xrd2 nlp2 outn 0 rppd w={RPPD_W} l={RPPD_L} m=1
R1 e1 em {RSHALF}
R2 em e2 {RSHALF}
Cdeg e1 e2 {CS}

XQ1 outp inp e1 s1 npn13G2 Nx={Nx}
Vs1 s1 0 dc 0
XQ2 outn inn e2 s2 npn13G2 Nx={Nx}
Vs2 s2 0 dc 0

Iref vdd mgate {ITAIL}
XMdiode mgate mgate 0 0 sg13_lv_nmos w={MOS_W_m} l={MOS_L_m} ng=1 m=1 rfmode=0
Xtail em mgate 0 0 sg13_lv_nmos w={MOS_W_m} l={MOS_L_m} ng=1 m=1 rfmode=0
.ends ctle_dut
