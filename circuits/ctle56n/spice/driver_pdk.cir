* 56G NRZ output pad driver — shunt-peaked CML + bond pad + ESD + line termination
.include '{IND_SHUNT_INC}'

.lib '{PDK_MODELS}/cornerHBT.lib' hbt_typ
.lib '{PDK_MODELS}/cornerMOSlv.lib' mos_tt
.lib '{PDK_MODELS}/cornerRES.lib' res_typ
.lib '{PDK_MODELS}/cornerCAP.lib' cap_typ
.lib '{PDK_MODELS}/cornerDIO.lib' dio_tt

* Pad cap: stacked TM1+TM2 70x70 um, TM1 bottom plate only (see docs/PDK.md).
.param PAD_W={PAD_W}
.param PAD_L={PAD_L}
.param PAD_C={PAD_C}

.subckt driver_dut outp outn inp inn vdd
* Shunt-peaked collectors (VDD -> L -> RD -> coll)
Xl1 vdd nlp1 0 ind_shunt
Xrd1 nlp1 coll_p 0 rppd w={RPPD_W} l={RPPD_L} m=1
Xl2 vdd nlp2 0 ind_shunt
Xrd2 nlp2 coll_n 0 rppd w={RPPD_W} l={RPPD_L} m=1

XQ1 coll_p inp e1 s1 npn13G2 Nx={Nx}
Vs1 s1 0 dc 0
XQ2 coll_n inn e2 s2 npn13G2 Nx={Nx}
Vs2 s2 0 dc 0

Iref vdd mgate {ITAIL}
XMdiode mgate mgate 0 0 sg13_lv_nmos w={MOS_W_m} l={MOS_L_m} ng=1 m=1 rfmode=0
Xtail1 e1 mgate 0 0 sg13_lv_nmos w={MOS_W_m} l={MOS_L_m} ng=1 m=1 rfmode=0
Xtail2 e2 mgate 0 0 sg13_lv_nmos w={MOS_W_m} l={MOS_L_m} ng=1 m=1 rfmode=0

* Series route coll -> pad (outp/outn are bond pads)
Rout_p coll_p outp {ROUT_SER}
Rout_n coll_n outn {ROUT_SER}

* Positive pad (outp)
Cpadp outp 0 {PAD_C}
Xesd_vdd_p vdd outp 0 diodevdd_2kv m={ESD_M}
Xesd_vss_p vdd outp 0 diodevss_2kv m={ESD_M}
Xrt_far_p outp vtt 0 rsil w={RSIL_W} l={RSIL_L} m=1
Rback_p outp vtt {BACK_RT_OHM}

* Negative pad (outn)
Cpadn outn 0 {PAD_C}
Xesd_vdd_n vdd outn 0 diodevdd_2kv m={ESD_M}
Xesd_vss_n vdd outn 0 diodevss_2kv m={ESD_M}
Xrt_far_n outn vtt 0 rsil w={RSIL_W} l={RSIL_L} m=1
Rback_n outn vtt {BACK_RT_OHM}

* Far-end common-mode reference (~1.4 V), shared with input termination
Xrtt_top vdd vtt 0 rppd w={VTT_RTOP_W} l={VTT_RTOP_L} m=1
Xrtt_bot vtt 0 0 rppd w={VTT_RBOT_W} l={VTT_RBOT_L} m=1
Xvtt_decap vtt 0 cap_cmim w={VTT_CAP_W} l={VTT_CAP_L} m=1
Xclamp vdd 0 nmoscl_2 m=1
.ends driver_dut
