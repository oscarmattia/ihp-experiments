* 56G NRZ output pad driver — shunt-peaked CML (no degeneration), pad + ESD
*
* Devices only: mirror reference current and pad capacitance are supplied by
* whoever instantiates this cell. Receiver termination is NOT in this block —
* floating 100 Ohm diff lives in the testbench.
.include '{IND_SHUNT_INC}'

.lib '{PDK_MODELS}/cornerHBT.lib' hbt_typ
.lib '{PDK_MODELS}/cornerMOSlv.lib' mos_tt
.lib '{PDK_MODELS}/cornerRES.lib' res_typ
.lib '{PDK_MODELS}/cornerDIO.lib' dio_tt

.param ESD_M={ESD_M}

.subckt driver_dut outp outn inp inn vdd vss mgate
* Shunt-peaked collectors: VDD -> L -> RD -> pad/collector
Xl1 vdd nlp1 vss ind_shunt_drv
Xrd1 nlp1 outp vss rsil w={RSIL_W} l={RSIL_L} m=1
Xl2 vdd nlp2 vss ind_shunt_drv
Xrd2 nlp2 outn vss rsil w={RSIL_W} l={RSIL_L} m=1

* HBT differential pair — shared emitter (no degeneration, no steering)
XQ1 outp inp em vss npn13G2 Nx={Nx}
XQ2 outn inn em vss npn13G2 Nx={Nx}

* Single MOS tail (2·Ic): mirror Iref=ITAIL/2 into W diode, 2W tail sinks ITAIL
XMdiode mgate mgate vss vss sg13_lv_nmos w={MOS_W_m} l={MOS_L_m} ng=1 m=1 rfmode=0
Xtail em mgate vss vss sg13_lv_nmos w={TAIL_W_m} l={MOS_L_m} ng=1 m=1 rfmode=0

* --- Pad + ESD (positive) — params PAD_*, ESD_M; pad cap is testbench-side ---
Xesd_vdd_p vdd outp vss diodevdd_2kv m={ESD_M}
Xesd_vss_p vdd outp vss diodevss_2kv m={ESD_M}
* --- Pad + ESD (negative) ---
Xesd_vdd_n vdd outn vss diodevdd_2kv m={ESD_M}
Xesd_vss_n vdd outn vss diodevss_2kv m={ESD_M}
Xclamp vdd vss nmoscl_2 m=1
.ends driver_dut
