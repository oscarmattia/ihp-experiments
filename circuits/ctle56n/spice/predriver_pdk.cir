* 56G CML pre-driver — shunt-peaked buffer between VGA and pad driver (no pad/ESD)
.include '{IND_SHUNT_INC}'

.lib '{PDK_MODELS}/cornerHBT.lib' hbt_typ
.lib '{PDK_MODELS}/cornerMOSlv.lib' mos_tt
.lib '{PDK_MODELS}/cornerRES.lib' res_typ

.subckt predriver_dut outp outn inp inn vdd
Xl1 vdd nlp1 0 ind_shunt
Xrd1 nlp1 outp 0 rppd w={RPPD_W} l={RPPD_L} m=1
Xl2 vdd nlp2 0 ind_shunt
Xrd2 nlp2 outn 0 rppd w={RPPD_W} l={RPPD_L} m=1

XQ1 outp inp e1 s1 npn13G2 Nx={Nx}
Vs1 s1 0 dc 0
XQ2 outn inn e2 s2 npn13G2 Nx={Nx}
Vs2 s2 0 dc 0

Iref vdd mgate {ITAIL}
XMdiode mgate mgate 0 0 sg13_lv_nmos w={MOS_W_m} l={MOS_L_m} ng=1 m=1 rfmode=0
Xtail1 e1 mgate 0 0 sg13_lv_nmos w={MOS_W_m} l={MOS_L_m} ng=1 m=1 rfmode=0
Xtail2 e2 mgate 0 0 sg13_lv_nmos w={MOS_W_m} l={MOS_L_m} ng=1 m=1 rfmode=0
.ends predriver_dut
