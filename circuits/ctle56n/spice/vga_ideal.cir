* 56G CML VGA DUT — ideal R/L, tail-current steering (signal + dummy pair)
*
* Devices only: tail mirror, input CM and steering gates are driven by whoever
* instantiates this cell. Fixed emitter degeneration was a 0.01 ohm placeholder
* short (RS_SIGNAL_OHM in size_vga.py); signal emitters share one node here.
* Dummy emitters remain separate — each has its own steering device off its tail.
* Reintroducing degeneration means size_vga.py emitting an rsil geometry.
.lib '{PDK_MODELS}/cornerHBT.lib' hbt_typ
.lib '{PDK_MODELS}/cornerMOSlv.lib' mos_tt

.subckt vga_dut outp outn inp inn vicm steerp steern vdd vss mgate
L1 vdd nlp1 {LLOAD}
RD1 nlp1 outp {RD}
L2 vdd nlp2 {LLOAD}
RD2 nlp2 outn {RD}

* Signal pair — FO1 input (inp/inn), shared emitter (was 0.01 ohm Rs short)
XQ1 outp inp em vss npn13G2 Nx={Nx}
XQ2 outn inn em vss npn13G2 Nx={Nx}

* Dummy pair — same shunt-peaked loads, bases at CM; independent emitters
XQd1 outp vicm ed1 vss npn13G2 Nx={Nx}
XQd2 outn vicm ed2 vss npn13G2 Nx={Nx}

XMdiode mgate mgate vss vss sg13_lv_nmos w={MOS_W_m} l={MOS_L_m} ng=1 m=1 rfmode=0

* Side 1: one mirrored tail per half; pass devices steer emitter current signal vs dummy
Xtail1 tx1 mgate vss vss sg13_lv_nmos w={MOS_W_m} l={MOS_L_m} ng=1 m=1 rfmode=0
Xps1 em steerp tx1 vss sg13_lv_nmos w={STEER_W_m} l={STEER_L_m} ng=1 m=1 rfmode=0
Xpd1 ed1 steern tx1 vss sg13_lv_nmos w={STEER_W_m} l={STEER_L_m} ng=1 m=1 rfmode=0

* Side 2
Xtail2 tx2 mgate vss vss sg13_lv_nmos w={MOS_W_m} l={MOS_L_m} ng=1 m=1 rfmode=0
Xps2 em steerp tx2 vss sg13_lv_nmos w={STEER_W_m} l={STEER_L_m} ng=1 m=1 rfmode=0
Xpd2 ed2 steern tx2 vss sg13_lv_nmos w={STEER_W_m} l={STEER_L_m} ng=1 m=1 rfmode=0
.ends vga_dut
