* 56G RX input termination — bond pad + ESD + 50 Ohm shunt to on-chip vtt
*
* Devices only: pad capacitance is hand-modelled in the testbench because the
* bondpad PCell has no electrical content (sg13g2_bondpad.lib is empty).
*
* Four ports: inp and inn are the differential pad nets. They are also the nets
* that leave the cell toward the CTLE — there is no separate output node because
* nothing sits between the pad and the next stage. In layout the bond pad is drawn
* on this net at the bottom edge of the cell; the same net exits at the top edge
* toward the CTLE.
*
* Geometry tokens supplied via size_term.py / extra_params (not params.inc).

.lib '{PDK_MODELS}/cornerRES.lib' res_typ
.lib '{PDK_MODELS}/cornerCAP.lib' cap_typ
.lib '{PDK_MODELS}/cornerDIO.lib' dio_tt
.lib '{PDK_MODELS}/cornerMOSlv.lib' mos_tt

.subckt term_dut inp inn vdd vss
* Positive side — bond pad / CTLE-facing net
Xesd_vdd_p vdd inp vss diodevdd_2kv m={ESD_M}
Xesd_vss_p vdd inp vss diodevss_2kv m={ESD_M}
Xrt_p inp vtt vss rsil w={RSIL_W} l={RSIL_L} m=1

* Negative side
Xesd_vdd_n vdd inn vss diodevdd_2kv m={ESD_M}
Xesd_vss_n vdd inn vss diodevss_2kv m={ESD_M}
Xrt_n inn vtt vss rsil w={RSIL_W} l={RSIL_L} m=1

* On-chip common-mode reference (~1.4 V). For differential signals vtt is a virtual
* ground (termination currents cancel); divider impedance matters mainly for CM.
Xrtt_top vdd vtt vss rppd w={VTT_RTOP_W} l={VTT_RTOP_L} m=1
Xrtt_bot vtt vss vss rppd w={VTT_RBOT_W} l={VTT_RBOT_L} m=1
Xvtt_decap vtt vss cap_cmim w={VTT_CAP_W} l={VTT_CAP_L} m=1

* Rail clamp for diode ESD current return between VDD and VSS
Xclamp vdd vss nmoscl_2 m=1
.ends term_dut
