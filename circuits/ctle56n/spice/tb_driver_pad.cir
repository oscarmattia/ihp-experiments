* Pad return loss — 1 A AC diff current, Z = |V(outp)-V(outn)| / 1 A
* Measure intrinsic pad impedance (no external Rterm — on-chip back-term only).
.include params.inc
.include {DUT_CIR}

Vdd vdd 0 dc {VDD}
XU1 {DUT_PORTS} {DUT_NAME}
{DUT_BIAS}
* Hold driver inputs at VGA output CM (AC ground)
Vcm_drv cm_drv 0 dc {VBASE}
Rcm_p cm_drv inp 1e9
Rcm_n cm_drv inn 1e9

* Unit AC diff current: I(Iac)=1 A → Z_diff = |V(outp)-V(outn)|
Iac outp outn dc 0 ac 1

.options gmin=1e-18 abstol=1e-15 reltol=1e-3

.control
save v(outp) v(outn)
ac dec 300 1e6 100e9
set wr_singlescale
wrdata zin_pad.raw frequency vm(outp) vp(outp) vm(outn) vp(outn)
.endc
.end
