* AC PSRR testbench — differential output vs VDD supply noise
* Inject AC on VDD (common-mode supply); inputs DC-only.
* PSRR = |v(vdd) / vod|  with vod = v(outp)-v(outn)
.include params.inc
.include {DUT_CIR}

Vdd vdd 0 dc {VDD} ac 1
XU1 {DUT_PORTS} {DUT_NAME}
{DUT_BIAS}
Vp inp 0 dc {VBASE}
Vn inn 0 dc {VBASE}

Cload_p outp 0 {CL_TB}
Cload_n outn 0 {CL_TB}

.options gmin=1e-18 abstol=1e-15 reltol=1e-3
{DUT_NODESET}

.control
save v(outp) v(outn) v(vdd)
ac dec 200 1e6 300e9
set wr_singlescale
wrdata ac_psrr.raw frequency vm(outp) vp(outp) vm(outn) vp(outn) vm(vdd) vp(vdd)
.endc
.end
